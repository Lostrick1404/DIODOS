** Profile: "SCHEMATIC1-CURVAS"  [ G:\6TO SEMESTRE\DIODOS Y TRANSISTORES\TRANSISTOR-PSpiceFiles\SCHEMATIC1\CURVAS.sim ]

** Creating circuit file "CURVAS.cir"
** WARNING: THIS AUTOMATICALLY GENERATED FILE MAY BE OVERWRITTEN BY SUBSEQUENT SIMULATIONS

*Libraries:
* Profile Libraries :
* Local Libraries :
.LIB "../../../transistor-pspicefiles/transistor_bc548b.lib"
* From [PSPICE NETLIST] section of C:\Users\jesus\AppData\Roaming\SPB_Data\cdssetup\OrCAD_PSpice\17.2.0\PSpice.ini file:
.lib "nomd.lib"

*Analysis directives:
.DC LIN V_V1 0 15 0.01
+ LIN I_I1 50u 400u 50u
.OPTIONS ADVCONV
.PROBE64 V(alias(*)) I(alias(*)) W(alias(*)) D(alias(*)) NOISE(alias(*))
.INC "..\SCHEMATIC1.net"

.END
