** Profile: "SCHEMATIC1-Curvas_Salida"  [ G:\6TO SEMESTRE\DIODOS Y TRANSISTORES\TRANSISTOR-PSpiceFiles\SCHEMATIC1\Curvas_Salida.sim ]

** Creating circuit file "Curvas_Salida.cir"
** WARNING: THIS AUTOMATICALLY GENERATED FILE MAY BE OVERWRITTEN BY SUBSEQUENT SIMULATIONS

*Libraries:
* Profile Libraries :
* Local Libraries :
.LIB "../../../transistor-pspicefiles/transistor_bc548b.lib"
* From [PSPICE NETLIST] section of C:\Users\jesus\AppData\Roaming\SPB_Data\cdssetup\OrCAD_PSpice\17.2.0\PSpice.ini file:
.lib "nomd.lib"

*Analysis directives:
.DC LIN V_V1 0V 15V 0.01V
+ LIN I1 50u 400u 50u
.OPTIONS ADVCONV
.PROBE64 V(alias(*)) I(alias(*)) W(alias(*)) D(alias(*)) NOISE(alias(*))
.INC "..\SCHEMATIC1.net"

.END
